** Profile: "SCHEMATIC1-whej"  [ E:\University\Communication Circuits\LAB\4\az4-SCHEMATIC1-whej.sim ]

** Creating circuit file "az4-SCHEMATIC1-whej.sim.cir"
** WARNING: THIS AUTOMATICALLY GENERATED FILE MAY BE OVERWRITTEN BY SUBSEQUENT SIMULATIONS

*Libraries:
* Local Libraries :
* From [PSPICE NETLIST] section of h:\softwares\orcad\new\PSpice\PSpice.ini file:
.lib "nom.lib"

*Analysis directives:
.TRAN  0 100u 90u
.PROBE V(*) I(*) W(*) D(*) NOISE(*)
.INC ".\az4-SCHEMATIC1.net"

.END
